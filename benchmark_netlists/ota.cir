* Simplified OTA
Vdd vdd 0 DC 5
Vin_p inp 0 DC 1.5 AC 0.5
Vin_n inn 0 DC 1.5 AC -0.5
Gm out 0 inp inn 1m
Rout out 0 100k
Cl out 0 10p
.ac dec 100 10 100Meg
.tran 1u 5m

.control
set noaskquit
save all
run
.endc

.end

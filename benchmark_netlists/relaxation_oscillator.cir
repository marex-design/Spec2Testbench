* RC Relaxation Oscillator Approximation
Vdd vdd 0 DC 5
R1 vdd cap 10k
C1 cap 0 100n
Ecmp out 0 VALUE = { V(cap) > 2.5 ? 0 : 5 }
Rfb out cap 100k
.tran 10u 20m

.control
set noaskquit
save all
run
.endc

.end

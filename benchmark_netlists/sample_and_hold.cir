* Sample and Hold Approximation
Vin in 0 SIN(0 1 1k)
Vclk clk 0 PULSE(0 5 0 1u 1u 0.2m 1m)
S1 in out clk 0 SW
Chold out 0 1n
Rload out 0 1Meg
.model SW SW RON=10 ROFF=1Meg VON=2 VOFF=1
.tran 1u 5m

.control
set noaskquit
save all
run
.endc

.end

* Simplified Voltage-Controlled Op-Amp
Vdd vdd 0 DC 15
Vss vss 0 DC -15
Vin_p inp 0 AC 0.5
Vin_n inn 0 AC -0.5
Eop out 0 inp inn 100000
Rout out vout 100
Cdom vout 0 10p
Rload vout 0 10k
.ac dec 100 1 100Meg
.tran 1u 5m

.control
set noaskquit
save all
run
.endc

.end

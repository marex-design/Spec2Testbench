* RC Differentiator
Vin in 0 PULSE(0 1 0 1u 1u 1m 2m)
C1 in out 100n
R1 out 0 1k
.tran 1u 5m

.control
set noaskquit
save all
run
.endc

.end

* Simplified Two-Stage Op-Amp
Vdd vdd 0 DC 5
Vin_p inp 0 AC 0.5
Vin_n inn 0 AC -0.5
G1 n1 0 inp inn 1m
R1 n1 0 100k
G2 out 0 n1 0 10m
Rout out 0 10k
Cc n1 out 1p
Cl out 0 10p
.ac dec 100 10 100Meg
.tran 1u 5m

.control
set noaskquit
save all
run
.endc

.end

* NMOS Current Mirror
Vdd vdd 0 DC 5
Iref vdd ref DC 100u
M1 ref ref 0 0 NMOS
M2 out ref 0 0 NMOS
Rload vdd out 20k
.model NMOS NMOS LEVEL=1 VTO=1 KP=1m LAMBDA=0.02 KF=0 AF=1
.op
.dc Vdd 3 5 0.1

.control
set noaskquit
save all
run
.endc

.end

* Transimpedance Amplifier Macro
Iin in 0 AC 1u SIN(0 1u 1k)
Rfb out in 100k
Eop out 0 0 in 1e5
Cfb out in 1p
Rload out 0 10k
.ac dec 100 10 100Meg

.control
set noaskquit
save all
run
.endc

.end

* Simplified Bandgap-Like Reference
Vdd vdd 0 DC 5
D1 n1 0 DIODE
D2 n2 0 DIODE
R1 vdd n1 10k
R2 vdd n2 20k
R3 n1 vref 5k
R4 n2 vref 5k
.model DIODE D IS=1e-14
.op
.dc temp -40 125 5

.control
set noaskquit
save all
run
.endc

.end

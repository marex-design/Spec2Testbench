* Simplified Folded Cascode Op-Amp Macro
Vdd vdd 0 DC 5
Vin_p inp 0 AC 0.5
Vin_n inn 0 AC -0.5
Gm n1 0 inp inn 1m
Rcas n1 out 100k
Cdom out 0 5p
Rload out 0 10k
.ac dec 100 10 100Meg

.control
set noaskquit
save all
run
.endc

.end

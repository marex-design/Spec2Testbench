* LC Tank Oscillator Approximation
Vinit n1 0 PULSE(0 1 0 1n 1n 10n 20n)
L1 n1 out 10u
C1 out 0 100p
Rloss out 0 10k
.tran 1n 10u

.control
set noaskquit
save all
run
.endc

.end

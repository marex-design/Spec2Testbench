* Source Follower
Vdd vdd 0 DC 5
Vin in 0 DC 2 AC 1
M1 vdd in out 0 NMOS
Rs out 0 2k
.model NMOS NMOS LEVEL=1 VTO=1 KP=1m LAMBDA=0.02 KF=0 AF=1
.op
.ac dec 100 10 10Meg

.control
set noaskquit
save all
run
.endc

.end

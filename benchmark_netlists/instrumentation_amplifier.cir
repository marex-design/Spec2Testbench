* Simplified Instrumentation Amplifier
Vin_p inp 0 AC 0.5
Vin_n inn 0 AC -0.5
E1 n1 0 inp inn 10
E2 out 0 n1 0 10
Rload out 0 10k
.ac dec 100 10 10Meg

.control
set noaskquit
save all
run
.endc

.end

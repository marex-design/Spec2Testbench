* Simple Diode Charge Pump
Vin in 0 PULSE(0 5 0 1n 1n 1u 2u)
C1 in n1 100n
D1 n1 out DIODE
D2 0 n1 DIODE
C2 out 0 100n
Rload out 0 10k
.model DIODE D IS=1e-14
.tran 10n 100u

.control
set noaskquit
save all
run
.endc

.end

* RC High-Pass Filter
Vin in 0 AC 1 SIN(0 1 1k)
C1 in out 159n
R1 out 0 1k
.ac dec 100 10 1Meg
.tran 1u 5m

.control
set noaskquit
save all
run
.endc

.end

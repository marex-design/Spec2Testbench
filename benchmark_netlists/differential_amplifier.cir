* NMOS Differential Amplifier
Vdd vdd 0 DC 5
V1 in_p 0 DC 1.5 AC 0.5
V2 in_n 0 DC 1.5 AC -0.5
M1 out_p in_p tail 0 NMOS
M2 out_n in_n tail 0 NMOS
R1 vdd out_p 10k
R2 vdd out_n 10k
Itail tail 0 DC 500u
.model NMOS NMOS LEVEL=1 VTO=1 KP=1m LAMBDA=0.02 KF=0 AF=1
.op
.ac dec 100 10 10Meg

.control
set noaskquit
save all
run
.endc

.end

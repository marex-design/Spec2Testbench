* RC Integrator
Vin in 0 PULSE(0 1 0 1u 1u 1m 2m)
R1 in out 10k
C1 out 0 1u
.tran 10u 10m

.control
set noaskquit
save all
run
.endc

.end

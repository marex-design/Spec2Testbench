* Half-Wave Rectifier
Vin in 0 SIN(0 5 1k)
D1 in out DIODE
Rload out 0 1k
.model DIODE D IS=1e-14
.tran 10u 10m

.control
set noaskquit
save all
run
.endc

.end

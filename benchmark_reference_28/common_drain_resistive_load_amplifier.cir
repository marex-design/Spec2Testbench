* Common-drain amplifier with resistive load
Vdd vdd 0 DC 5
Vin in 0 DC 2 AC 1 SIN(2 10m 1k)
M1 vdd in out 0 NMOS
Rs out 0 2k
.model NMOS NMOS LEVEL=1 VTO=1 KP=1m
.op
.ac dec 100 10 10Meg
.tran 1u 5m
.end

* Passive low-pass filter
Vin in 0 AC 1 SIN(0 1 1k)
R1 in out 1k
C1 out 0 159n
.ac dec 100 10 1Meg
.tran 1u 5m
.end

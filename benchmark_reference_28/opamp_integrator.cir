* Op-amp integrator
Vin in 0 PULSE(0 1 0 1u 1u 1m 2m)
Rin in nminus 10k
Cfb out nminus 1u
Eop out 0 0 nminus 1e5
Rbias nminus 0 1Meg
.tran 10u 10m
.end

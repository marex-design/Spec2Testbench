* Wien Bridge oscillator approximation
Vdd vdd 0 DC 12
Bosc out 0 V = 2*sin(2*3.14159*1k*time)
R1 out n1 10k
C1 n1 0 15.9n
R2 n1 fb 10k
C2 fb out 15.9n
Rload out 0 100k
.tran 10u 20m
.end

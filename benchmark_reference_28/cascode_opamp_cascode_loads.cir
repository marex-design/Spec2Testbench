* Cascode op-amp with cascode loads
Vdd vdd 0 DC 5
Vin_p inp 0 AC 0.5
Vin_n inn 0 AC -0.5
Gm n1 0 inp inn 1m
Rcas n1 out 100k
Rload out 0 10k
Cdom out 0 5p
.ac dec 100 10 100Meg
.end

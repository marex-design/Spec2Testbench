* High-Pass RC Filter
C1 in out 1n
R1 out 0 1k
Vin in 0 AC 1

.ac dec 100 10 10e6

.meas ac cutoff_frequency_hz when vdb(out)=-3

.control
run
print cutoff_frequency_hz
.endc
.end

* Low-Pass RC Filter
R1 in out 1k
C1 out 0 1n
Vin in 0 AC 1

.ac dec 100 10 10e6

.meas ac cutoff_frequency_hz when vdb(out)=-3

.control
run
print cutoff_frequency_hz
.endc
.end

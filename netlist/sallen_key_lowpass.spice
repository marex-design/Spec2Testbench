* Sallen-Key Low-Pass Filter
* Cutoff frequency = 1/(2*pi*R*C) = 159 kHz
R1 in n1 1k
R2 n1 n2 1k
C1 n1 out 1n
C2 n2 0 1n
Xopamp n2 n1 out opamp
.model opamp opamp level=1
Vin in 0 AC 1
Rload out 0 1MEG

.subckt opamp in+ in- out
Eamp out 0 in+ in- 1e5
.ends

.ac dec 100 10 10e6

.meas ac cutoff when vdb(out)=-3
.meas ac gain_max max vdb(out)

.control
run
print cutoff
print gain_max
.endc
.end

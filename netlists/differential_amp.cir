* Differential amplifier with current-source tail
.model NMOS NMOS
.model PMOS PMOS
M1 out1 in1 tail vdd PMOS
M2 out2 in2 tail vdd PMOS
M3 tail bias 0 0 NMOS
R1 out1 0 10k
R2 out2 0 10k
Vdd vdd 0 1.8
Vbias bias 0 0.6
Vin1 in1 0 0.9
Vin2 in2 0 0.9
.end

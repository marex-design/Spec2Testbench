* 3-stage CMOS ring oscillator
.model NMOS NMOS
.model PMOS PMOS
M1 n1 n3 0   0   NMOS
M2 n1 n3 vdd vdd PMOS
M3 n2 n1 0   0   NMOS
M4 n2 n1 vdd vdd PMOS
M5 n3 n2 0   0   NMOS
M6 n3 n2 vdd vdd PMOS
Vdd vdd 0 1.8
.end

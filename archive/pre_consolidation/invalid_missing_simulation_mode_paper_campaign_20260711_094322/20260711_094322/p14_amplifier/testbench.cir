* TestBench: analogcoder_pro_p14_amplifier_full_testbench
* Category: full
* Circuit: analogcoder_pro_p14_amplifier

analogcoder_pro_p14_amplifier
.INCLUDE E:\my_organisation\Memoire Maruba\code\Spec2Testbench\benchmark\analogcoder_pro\p14_amplifier.cir
Vvin Vin 0 2.5
Vvin Vin 0 AC 1
.OP
.AC dec 10 1 1000000000.0
.END

* TestBench: analogcoder_pro_p11_highpass_full_testbench
* Category: full
* Circuit: analogcoder_pro_p11_highpass

analogcoder_pro_p11_highpass
.INCLUDE E:\my_organisation\Memoire Maruba\code\Spec2Testbench\benchmark\analogcoder_pro\p11_highpass.cir
Vvin Vin 0 AC 1
.AC dec 10 1 1000000000.0
.END

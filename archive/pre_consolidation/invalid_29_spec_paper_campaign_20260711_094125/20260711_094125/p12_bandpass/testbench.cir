* TestBench: analogcoder_pro_p12_bandpass_full_testbench
* Category: full
* Circuit: analogcoder_pro_p12_bandpass

analogcoder_pro_p12_bandpass
.INCLUDE E:\my_organisation\Memoire Maruba\code\Spec2Testbench\benchmark\analogcoder_pro\p12_bandpass.cir
Vvin Vin 0 AC 1
.AC dec 10 1 1000000000.0
.END

* TestBench: analogcoder_pro_p19_mixer_full_testbench
* Category: full
* Circuit: analogcoder_pro_p19_mixer

analogcoder_pro_p19_mixer
.INCLUDE E:\my_organisation\Memoire Maruba\code\Spec2Testbench\benchmark\analogcoder_pro\p19_mixer.cir
Vvin Vrfp 0 SIN(2.5 1.25 1000000.0)
.TRAN 5e-09 5e-05 0
.FOUR 1000000.0 V(Voutp)
.END

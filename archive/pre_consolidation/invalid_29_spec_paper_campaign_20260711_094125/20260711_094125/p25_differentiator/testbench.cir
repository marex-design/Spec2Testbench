* TestBench: analogcoder_pro_p25_differentiator_full_testbench
* Category: full
* Circuit: analogcoder_pro_p25_differentiator

analogcoder_pro_p25_differentiator
.INCLUDE E:\my_organisation\Memoire Maruba\code\Spec2Testbench\benchmark\analogcoder_pro\p25_differentiator.cir
Vvin Vin 0 PULSE(1.25 3.75 0 1n 1n 10u 20u)
.TRAN 1n 50u 0
.END

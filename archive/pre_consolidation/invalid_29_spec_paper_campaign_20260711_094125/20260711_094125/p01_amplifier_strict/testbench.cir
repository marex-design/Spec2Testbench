* TestBench: analogcoder_pro_p01_amplifier_strict_full_testbench
* Category: full
* Circuit: analogcoder_pro_p01_amplifier_strict

analogcoder_pro_p01_amplifier_strict
.INCLUDE E:\my_organisation\Memoire Maruba\code\Spec2Testbench\benchmark\analogcoder_pro\p01_amplifier_strict.cir
Vvin Vin 0 0.8
Vvin Vin 0 AC 1
.OP
.AC dec 10 1 1000000000.0
.END

* TestBench: analogcoder_pro_p08_currentmirror_full_testbench
* Category: full
* Circuit: analogcoder_pro_p08_currentmirror

analogcoder_pro_p08_currentmirror
.INCLUDE E:\my_organisation\Memoire Maruba\code\Spec2Testbench\benchmark\analogcoder_pro\p08_currentmirror.cir
.DC vdd 5.0 5.0 0.05
.END

* TestBench: analogcoder_pro_p03_amplifier_full_testbench
* Circuit: analogcoder_pro_p03_amplifier
* Category: full
*
.OPTIONS POST=2 PROBE

* AnalogCoder-Pro p3: A common-drain amplifier (a.k.a. a source follower) with resistive load R (output Vout at the source)
* Source: analogcoder\AnalogCoderPro-master\sample_design\p3\p3.py
* AnalogCoder-Pro type: Amplifier
* Inputs: Vin
* Outputs: Vout

.MODEL nmos NMOS (LEVEL=1 VTO=0.5 KP=0.0001)

Vdd Vdd 0 5
Vin Vin 0 DC 1.0 AC 1n
Rload Vout 0 10k
M1 Vdd Vin Vout Vout nmos W=5e-05 L=1e-06

.OP
.AC DEC 100 1 1G

.TEMP 27.0
Vvin Vin 0 2.5
.TRAN 1n 50u 0

.END

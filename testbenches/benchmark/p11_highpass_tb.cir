* TestBench: analogcoder_pro_p11_highpass_full_testbench
* Circuit: analogcoder_pro_p11_highpass
* Category: full
*
.OPTIONS POST=2 PROBE

* AnalogCoder-Pro p11: a passive high-pass filter
* Source: analogcoder\AnalogCoderPro-master\sample_design\p11\p11.py
* AnalogCoder-Pro type: HighPass
* Inputs: Vin
* Outputs: Vout

Vin Vin 0 1
C1 Vin Vout 10n
R1 Vout 0 10k

.AC DEC 100 1 1G

.TEMP 27.0
Vvin Vin 0 AC 1
.TRAN 1n 50u 0

.END

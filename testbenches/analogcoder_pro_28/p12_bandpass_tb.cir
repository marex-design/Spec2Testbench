* TestBench: analogcoder_pro_p12_bandpass_full_testbench
* Circuit: analogcoder_pro_p12_bandpass
* Category: full
*
.OPTIONS POST=2 PROBE

* AnalogCoder-Pro p12: a passive band-pass filter
* Source: analogcoder\AnalogCoderPro-master\sample_design\p12\p12.py
* AnalogCoder-Pro type: BandPass
* Inputs: Vin
* Outputs: Vout

Vin Vin 0 1
C1 Vin N1 10n
R1 N1 0 10k
R2 N1 Vout 10k
C2 Vout 0 10n

.AC DEC 100 1 1G

.TEMP 27.0
.TRAN 1n 50u 0

.END

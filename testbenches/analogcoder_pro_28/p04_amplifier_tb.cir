* TestBench: analogcoder_pro_p04_amplifier_full_testbench
* Circuit: analogcoder_pro_p04_amplifier
* Category: full
*
.OPTIONS POST=2 PROBE

* AnalogCoder-Pro p4: A single-stage common-gate amplifier with resistive load R (input signal Vin must be applied at the source terminal)
* Source: analogcoder\AnalogCoderPro-master\sample_design\p4\p4.py
* AnalogCoder-Pro type: Amplifier
* Inputs: Vin, Vbias
* Outputs: Vout

.MODEL nmos_model NMOS (LEVEL=1 KP=0.0001 VTO=0.5)

Vdd Vdd 0 5
Vbias Vbias 0 2
Vin Vin 0 DC 0.5 AC 1n
M1 Vout Vbias Vin Vin nmos_model W=5e-05 L=1e-06
Rload Vout Vdd 10000

.OP
.AC DEC 100 1 1G

.TEMP 27.0
.TRAN 1n 50u 0

.END

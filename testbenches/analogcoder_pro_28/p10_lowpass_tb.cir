* TestBench: analogcoder_pro_p10_lowpass_full_testbench
* Circuit: analogcoder_pro_p10_lowpass
* Category: full
*
.OPTIONS POST=2 PROBE

* AnalogCoder-Pro p10: a passive low-pass filter
* Source: analogcoder\AnalogCoderPro-master\sample_design\p10\p10.py
* AnalogCoder-Pro type: LowPass
* Inputs: Vin
* Outputs: Vout

Vin Vin 0 1
R1 Vin Vout 10k
C1 Vout 0 10n

.AC DEC 100 1 1G

.TEMP 27.0
.TRAN 1n 50u 0

.END

* TestBench: analogcoder_pro_p21_opamp_full_testbench
* Circuit: analogcoder_pro_p21_opamp
* Category: full
*
.OPTIONS POST=2 PROBE

* AnalogCoder-Pro p21: A single-stage telescopic cascode opamp with two outputs (4 nmos as cascode input pair, 4 pmos as cascode loads, and 1 tail current)
* Source: analogcoder\AnalogCoderPro-master\sample_design\p21\p21.py
* AnalogCoder-Pro type: Opamp
* Inputs: Vinp, Vinn, Vbias1, Vbias2, Vbias3, Vbias4
* Outputs: Voutp, Vout

.MODEL nmos_model NMOS (LEVEL=1 KP=0.0001 VTO=0.5)
.MODEL pmos_model PMOS (LEVEL=1 KP=5e-05 VTO=-0.5)

Vdd Vdd 0 5
Vinp Vinp 0 DC 1.0 AC 1n
Vinn Vinn 0 DC 1.0 AC 1n
Vbias1 Vbias1 0 0.7
Vbias2 Vbias2 0 1.2
Vbias3 Vbias3 0 4
Vbias4 Vbias4 0 3.5
M9 S_tail Vbias1 0 0 nmos_model W=3e-05 L=1e-06
M1 N1 Vinp S_tail S_tail nmos_model W=5e-05 L=1e-06
M2 N2 Vinn S_tail S_tail nmos_model W=5e-05 L=1e-06
M3 Voutp Vbias2 N1 N1 nmos_model W=5e-05 L=1e-06
M4 Vout Vbias2 N2 N2 nmos_model W=5e-05 L=1e-06
M5 Voutp Vbias3 S5 S5 pmos_model W=7e-05 L=1e-06
M6 Vout Vbias3 S6 S6 pmos_model W=7e-05 L=1e-06
M7 S5 Vbias4 Vdd Vdd pmos_model W=7e-05 L=1e-06
M8 S6 Vbias4 Vdd Vdd pmos_model W=7e-05 L=1e-06

.OP
.AC DEC 100 1 1G

.TEMP 27.0
.TRAN 1n 50u 0

.END

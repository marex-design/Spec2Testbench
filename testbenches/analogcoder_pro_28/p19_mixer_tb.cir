* TestBench: analogcoder_pro_p19_mixer_full_testbench
* Circuit: analogcoder_pro_p19_mixer
* Category: full
*
.OPTIONS POST=2 PROBE

* AnalogCoder-Pro p19: A Gilbert cell mixer to make Voutp - Voutn ∝ (Vrfp - Vrfn) × (Vlop - Vlon)
* Source: analogcoder\AnalogCoderPro-master\sample_design\p19\p19.py
* AnalogCoder-Pro type: Mixer
* Inputs: Vrfp, Vrfn, Vlop, Vlon
* Outputs: Voutp, Voutn

.MODEL nmos_model NMOS (LEVEL=1 KP=0.0001 VTO=0.7)

Vdd Vdd 0 5
Vbias Vbias 0 1.5
Vrfp Vrfp 0 2.5
Vrfn Vrfn 0 2.5
Vlop Vlop 0 3
Vlon Vlon 0 2
RL1 Vdd Voutp 1k
RL2 Vdd Voutn 1k
M7 SourceNode Vbias 0 0 nmos_model W=0.0001 L=1e-06
M1 RFp_out Vrfp SourceNode 0 nmos_model W=5e-05 L=1e-06
M2 RFn_out Vrfn SourceNode 0 nmos_model W=5e-05 L=1e-06
M3 Voutp Vlop RFp_out 0 nmos_model W=5e-05 L=1e-06
M4 Voutp Vlon RFn_out 0 nmos_model W=5e-05 L=1e-06
M5 Voutn Vlon RFp_out 0 nmos_model W=5e-05 L=1e-06
M6 Voutn Vlop RFn_out 0 nmos_model W=5e-05 L=1e-06

.TRAN 1U 20M

.TEMP 27.0
* Analysis fourier not yet implemented

.END

* TestBench: analogcoder_pro_p13_bandstop_full_testbench
* Circuit: analogcoder_pro_p13_bandstop
* Category: full
*
.OPTIONS POST=2 PROBE

* AnalogCoder-Pro p13: a passive band-stop filter
* Source: analogcoder\AnalogCoderPro-master\sample_design\p13\p13.py
* AnalogCoder-Pro type: BandStop
* Inputs: Vin
* Outputs: Vout

Vin Vin 0 1
R1 Vin Vout 1k
L1 Vout N1 10m
C1 N1 0 10n

.AC DEC 100 1 1G

.TEMP 27.0
.TRAN 1n 50u 0

.END

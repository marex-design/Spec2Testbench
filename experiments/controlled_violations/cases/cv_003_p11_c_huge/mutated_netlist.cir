* Canonical DUT generated from benchmark/analogcoder_pro/p11_highpass.cir
* Embedded analyses and output directives were externalized into metadata.
* AnalogCoder-Pro p11: a passive high-pass filter
* Source: analogcoder\AnalogCoderPro-master\sample_design\p11\p11.py
* AnalogCoder-Pro type: HighPass
* Inputs: Vin
* Outputs: Vout
* original signal source: Vin Vin 0 1
Vin Vin 0 0
C1 Vin Vout 1
R1 Vout 0 10k
* original analysis: .AC DEC 100 1 1G
.END

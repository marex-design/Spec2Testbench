* Canonical DUT generated from benchmark/analogcoder_pro/p08_currentmirror.cir
* Embedded analyses and output directives were externalized into metadata.
* AnalogCoder-Pro p8: A simple NMOS constant current source with resistive load R
* Source: analogcoder\AnalogCoderPro-master\sample_design\p8\p8.py
* AnalogCoder-Pro type: CurrentMirror
* Inputs: Vbias
* Outputs: Vout
.MODEL nmos NMOS (LEVEL=1 VTO=0.5 KP=0.0002)
Vdd Vdd 0 5
Vbias Vbias 0 1
M1 Vout Vbias 0 0 nmos W=1e-05 L=1e-06
Rload Vout Vdd 1
* original analysis: .OP
* original analysis: .DC Vdd 0 5 0.1
.END

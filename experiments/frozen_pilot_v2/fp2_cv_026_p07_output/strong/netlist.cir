* AnalogCoder-Pro p7: A logical inverter with 1 NMOS and 1 PMOS
* Source: analogcoder\AnalogCoderPro-master\sample_design\p7\p7.py
* AnalogCoder-Pro type: Inverter
* Inputs: Vin
* Outputs: Vout

.MODEL nmos NMOS (LEVEL=1 VTO=0.7 KP=0.002)
.MODEL pmos PMOS (LEVEL=1 VTO=-0.7 KP=0.0015)

Vdd Vdd 0 0.1
Vin Vin 0 0
M_N Vout Vin 0 0 nmos W=1e-05 L=1e-06
M_P Vout Vin Vdd Vdd pmos W=1e-05 L=1e-06

.OP
.TRAN 1N 10U
.END

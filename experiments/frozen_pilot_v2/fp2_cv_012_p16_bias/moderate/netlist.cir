* AnalogCoder-Pro p16: A differential opamp with an active PMOS current mirror load, a tail current source, and two outputs
* Source: analogcoder\AnalogCoderPro-master\sample_design\p16\p16.py
* AnalogCoder-Pro type: Opamp
* Inputs: Vinp, Vinn, Vbias
* Outputs: Voutp, Vout

.MODEL nmos_model NMOS (LEVEL=1 KP=0.0001 VTO=0.5)
.MODEL pmos_model PMOS (LEVEL=1 KP=5e-05 VTO=-0.5)

Vdd Vdd 0 1.0
Vinp Vinp 0 DC 1.0 AC 1n
Vinn Vinn 0 DC 1.0 AC 1n
Vbias Vbias 0 1
Mtail Stail Vbias 0 0 nmos_model W=5e-05 L=1e-06
M1 Voutp Vinp Stail Stail nmos_model W=5e-05 L=1e-06
M2 Vout Vinn Stail Stail nmos_model W=5e-05 L=1e-06
M3 Voutp Voutp Vdd Vdd pmos_model W=0.0001 L=1e-06
M4 Vout Voutp Vdd Vdd pmos_model W=0.0001 L=1e-06

.OP
.AC DEC 100 1 1G
.END

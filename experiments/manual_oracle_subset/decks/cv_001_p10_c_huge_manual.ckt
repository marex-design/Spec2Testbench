* Independent manual oracle — p10 low-pass controlled violation
* C1 is intentionally 1 F. Authored independently of Spec2Testbench.
Vin Vin 0 AC 1
R1 Vin Vout 10k
C1 Vout 0 1
.ac dec 100 1e-8 1e9
.meas ac cutoff_frequency_hz WHEN vdb(Vout)=-3 CROSS=1
.end

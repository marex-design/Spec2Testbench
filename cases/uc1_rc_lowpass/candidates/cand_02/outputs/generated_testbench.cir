* UC1 RC Low-Pass Filter - Candidate 02 (PASS candidate)

V1 vin 0 DC 0 AC 1
Rs vin in 1k
Rfilter in out 1k
Cfilter out 0 389n
Rload out 0 100k

.ac lin 2000 10 20000

.control
run
* Test: ac_gain_at_frequency
let gain_mag = mag(v(out))
meas ac gain_200Hz_mag FIND gain_mag AT=200

* Test: ac_attenuation_at_frequency
let gain_mag = mag(v(out))
meas ac gain_2kHz_mag FIND gain_mag AT=2000
.endc

.end

* Example Case - RC Low-Pass Filter
* Candidate circuit only

V1 vin 0 DC 0 AC 1
Rs vin in 1k
Rfilter in out 1k
Cfilter out 0 820n
Rload out 0 100k

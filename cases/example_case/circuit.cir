* Example Case - RC Low-Pass Filter

V1 vin 0 DC 0 AC 1
Rs vin in 1k
Rfilter in out 1k
Cfilter out 0 820n
Rload out 0 100k

.ac lin 2000 10 20000

.control
run
let magout = mag(v(out))
meas ac gain_200Hz_mag FIND magout AT=200
meas ac gain_2kHz_mag FIND magout AT=2000
.endc

.end

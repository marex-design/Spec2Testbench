* RC Low-pass filter AC analysis
R1 in out 1k
C1 out 0 1n
Vin in 0 AC 1
.AC DEC 100 10 1e9
.control
run
plot vdb(out)
meas ac cutoff when vdb(out)=-3
.endc
.end

* Canonical DUT generated from benchmark/analogcoder_pro/p12_bandpass.cir
* Embedded analyses and output directives were externalized into metadata.
* AnalogCoder-Pro p12: a passive band-pass filter
* Source: analogcoder\AnalogCoderPro-master\sample_design\p12\p12.py
* AnalogCoder-Pro type: BandPass
* Inputs: Vin
* Outputs: Vout
* original signal source: Vin Vin 0 1
Vin Vin 0 0
C1 Vin N1 10n
R1 N1 0 10k
R2 N1 Vout 10k
C2 Vout 0 10n

* Canonical DUT generated from benchmark/analogcoder_pro/p26_adder.cir
* Embedded analyses and output directives were externalized into metadata.
* AnalogCoder-Pro p26: An Opamp adder to make Vout=-(Vin1+Vin2)
* Source: analogcoder\AnalogCoderPro-master\sample_design\p26\p26.py
* AnalogCoder-Pro type: Adder
* Inputs: Vin1, Vin2
* Outputs: Vout
* Opamp subcircuit imported from AnalogCoder-Pro opamp.py
.SUBCKT Opamp Vinp Vinn Vout
.MODEL nmos_model NMOS (LEVEL=1 KP=0.0001 VTO=0.5)
.MODEL pmos_model PMOS (LEVEL=1 KP=5e-05 VTO=-0.5)
Vdd Vdd 0 5
Vbias Vbias 0 1.5
M1 Voutp Vinp Source3 Source3 nmos_model W=5e-05 L=1e-06
M2 Vout Vinn Source3 Source3 nmos_model W=5e-05 L=1e-06
M3 Source3 Vbias 0 0 nmos_model W=0.0001 L=1e-06
M4 Voutp Voutp Vdd Vdd pmos_model W=0.0001 L=1e-06
M5 Vout Voutp Vdd Vdd pmos_model W=0.0001 L=1e-06
.ENDS Opamp
Vdd Vdd 0 5
Vref Vref 0 2.5
* original signal source: Vin1 Vin1 0 3
Vin1 Vin1 0 0
* original signal source: Vin2 Vin2 0 3
Vin2 Vin2 0 0
R1 Vin1 Vsum 10k
R2 Vin2 Vsum 10k
Rf Vout Vsum 10k
Xop Vref Vsum Vout Opamp

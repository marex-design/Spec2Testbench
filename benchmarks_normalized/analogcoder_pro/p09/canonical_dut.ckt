* Canonical DUT generated from benchmark/analogcoder_pro/p09_comparator.cir
* Embedded analyses and output directives were externalized into metadata.
* AnalogCoder-Pro p9: an op-amp comparator to make the output high when Vin > Vref and low when Vin < Vref
* Source: analogcoder\AnalogCoderPro-master\sample_design\p9\p9.py
* AnalogCoder-Pro type: Comparator
* Inputs: Vin
* Outputs: Vout
* Opamp subcircuit imported from AnalogCoder-Pro opamp.py
.SUBCKT Opamp Vinp Vinn Vout
.MODEL nmos_model NMOS (LEVEL=1 KP=0.0001 VTO=0.5)
.MODEL pmos_model PMOS (LEVEL=1 KP=5e-05 VTO=-0.5)
Vdd Vdd 0 5
Vbias Vbias 0 1.5
M1 Voutp Vinp Source3 Source3 nmos_model W=5e-05 L=1e-06
M2 Vout Vinn Source3 Source3 nmos_model W=5e-05 L=1e-06
M3 Source3 Vbias 0 0 nmos_model W=0.0001 L=1e-06
M4 Voutp Voutp Vdd Vdd pmos_model W=0.0001 L=1e-06
M5 Vout Voutp Vdd Vdd pmos_model W=0.0001 L=1e-06
.ENDS Opamp
Vdd Vdd 0 5
Vref Vref 0 2.5
* original signal source: Vin Vin 0 3
Vin Vin 0 0
Xcmp Vin Vref Vout Opamp

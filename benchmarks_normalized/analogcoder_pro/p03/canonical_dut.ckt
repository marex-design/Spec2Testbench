* Canonical DUT generated from benchmark/analogcoder_pro/p03_amplifier.cir
* Embedded analyses and output directives were externalized into metadata.
* AnalogCoder-Pro p3: A common-drain amplifier (a.k.a. a source follower) with resistive load R (output Vout at the source)
* Source: analogcoder\AnalogCoderPro-master\sample_design\p3\p3.py
* AnalogCoder-Pro type: Amplifier
* Inputs: Vin
* Outputs: Vout
.MODEL nmos NMOS (LEVEL=1 VTO=0.5 KP=0.0001)
Vdd Vdd 0 5
* original signal source: Vin Vin 0 DC 1.0 AC 1n
Vin Vin 0 0
Rload Vout 0 10k
M1 Vdd Vin Vout Vout nmos W=5e-05 L=1e-06

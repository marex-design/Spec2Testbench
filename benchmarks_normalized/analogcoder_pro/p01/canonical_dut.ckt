* Canonical DUT generated from benchmark/analogcoder_pro/p01_amplifier.cir
* Embedded analyses and output directives were externalized into metadata.
* AnalogCoder-Pro p1: a single-stage common-source amplifier with resistive load R
* Source: analogcoder\AnalogCoderPro-master\sample_design\p1\p1.py
* AnalogCoder-Pro type: Amplifier
* Inputs: Vin
* Outputs: Vout
.MODEL nmos_model NMOS (LEVEL=1 KP=0.0001 VTO=0.5)
Vdd Vdd 0 5
* original signal source: Vin Vin 0 DC 1.0 AC 1n
Vin Vin 0 0
Rload Vout Vdd 10k
M1 Vout Vin 0 0 nmos_model W=5e-05 L=1e-06

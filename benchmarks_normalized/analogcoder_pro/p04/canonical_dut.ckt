* Canonical DUT generated from benchmark/analogcoder_pro/p04_amplifier.cir
* Embedded analyses and output directives were externalized into metadata.
* AnalogCoder-Pro p4: A single-stage common-gate amplifier with resistive load R (input signal Vin must be applied at the source terminal)
* Source: analogcoder\AnalogCoderPro-master\sample_design\p4\p4.py
* AnalogCoder-Pro type: Amplifier
* Inputs: Vin, Vbias
* Outputs: Vout
.MODEL nmos_model NMOS (LEVEL=1 KP=0.0001 VTO=0.5)
Vdd Vdd 0 5
Vbias Vbias 0 2
* original signal source: Vin Vin 0 DC 0.5 AC 1n
Vin Vin 0 0
M1 Vout Vbias Vin Vin nmos_model W=5e-05 L=1e-06
Rload Vout Vdd 10000

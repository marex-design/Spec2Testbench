* TestBench: analogcoder_pro_p13_bandstop_full_testbench
* Category: full
* Circuit: analogcoder_pro_p13_bandstop

analogcoder_pro_p13_bandstop
.INCLUDE E:\my_organisation\Memoire Maruba\code\Spec2Testbench\benchmark\analogcoder_pro\p13_bandstop.cir
Vvin Vin 0 AC 1
.AC dec 10 1 1000000000.0
.END

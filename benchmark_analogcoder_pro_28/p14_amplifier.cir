* AnalogCoder-Pro p14: A two-stage amplifier with a Miller compensation capacitor
* Source: analogcoder\AnalogCoderPro-master\sample_design\p14\p14.py
* AnalogCoder-Pro type: Amplifier
* Inputs: Vin
* Outputs: Vout

.MODEL nmos NMOS (LEVEL=1 VTO=0.5 KP=0.0001)
.MODEL pmos PMOS (LEVEL=1 VTO=-0.5 KP=5e-05)

Vdd Vdd 0 5
Vbias Vbias 0 2.5
M1 Vmid Vin 0 0 nmos W=1e-05 L=1e-06
M2 Vmid Vbias Vdd Vdd pmos W=2e-05 L=1e-06
M3 Vout Vmid 0 0 nmos W=1e-05 L=1e-06
Rload Vout Vdd 10k
Cmiller Vmid Vout 1p
Vin Vin 0 DC 1 AC 1n

.OP
.AC DEC 100 1 1G
.END

* AnalogCoder-Pro p6: A NMOS inverter with resistive load R
* Source: analogcoder\AnalogCoderPro-master\sample_design\p6\p6.py
* AnalogCoder-Pro type: Inverter
* Inputs: Vin
* Outputs: Vout

.MODEL nmos NMOS (LEVEL=1 KP=0.0002 VTO=0.7)

Vdd Vdd 0 5
Vin Vin 0 0
Rload Vdd Vout 100k
M1 Vout Vin 0 0 nmos

.OP
.TRAN 1N 10U
.END

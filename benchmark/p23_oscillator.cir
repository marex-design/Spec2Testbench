* AnalogCoder-Pro p23: A Wien Bridge oscillator
* Source: analogcoder\AnalogCoderPro-master\sample_design\p23\p23.py
* AnalogCoder-Pro type: Oscillator
* Inputs: -
* Outputs: Vout

* Opamp subcircuit imported from AnalogCoder-Pro opamp.py
.SUBCKT Opamp Vinp Vinn Vout
.MODEL nmos_model NMOS (LEVEL=1 KP=0.0001 VTO=0.5)
.MODEL pmos_model PMOS (LEVEL=1 KP=5e-05 VTO=-0.5)
Vdd Vdd 0 5
Vbias Vbias 0 1.5
M1 Voutp Vinp Source3 Source3 nmos_model W=5e-05 L=1e-06
M2 Vout Vinn Source3 Source3 nmos_model W=5e-05 L=1e-06
M3 Source3 Vbias 0 0 nmos_model W=0.0001 L=1e-06
M4 Voutp Voutp Vdd Vdd pmos_model W=0.0001 L=1e-06
M5 Vout Voutp Vdd Vdd pmos_model W=0.0001 L=1e-06
.ENDS Opamp

Vdd Vdd 0 5
Vref Vref 0 2.5
R1 Vout N1 10k
C1 N1 N2 10n
R2 N2 Vref 10k
C2 N2 Vref 10n
Rf1 Vout Vinn 21k
Rf2 Vinn Vref 10k
X1 N2 Vinn Vout Opamp

.TRAN 10U 20M
.END

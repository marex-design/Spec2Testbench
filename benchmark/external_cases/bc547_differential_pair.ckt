* ============================================================
* BC547A differential pair
* External pedagogical case for Spec2Testbench
* DUT only - no analysis commands
* ============================================================

.include benchmark/external_cases/models/bc547.txt

Q1 c1 b1 e bc547a
Q2 c2 b2 e bc547a

VC1 V01 c1 0
VC2 V02 c2 0
VE  e VdE 0

RC1 VCC c1 6.8k
RC2 VCC c2 6.8k

RB1 b1 Vin1 1k
RB2 b2 Vin2 1k

RE VdE VEE 10k

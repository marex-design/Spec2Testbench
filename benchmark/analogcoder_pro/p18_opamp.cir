* AnalogCoder-Pro p18: A single-stage differential common-source opamp with dual resistive loads, tail current, and a single output
* Source: analogcoder\AnalogCoderPro-master\sample_design\p18\p18.py
* AnalogCoder-Pro type: Opamp
* Inputs: Vinp, Vinn
* Outputs: Vout

.MODEL nmos_model NMOS (LEVEL=1 KP=0.0001 VTO=0.5)

Vdd Vdd 0 5
Vinp Vinp 0 DC 1.0 AC 1n
Vinn Vinn 0 DC 1.0 AC 1n
Vbias Vbias 0 1
M1 Vout Vinp SourceDiff SourceDiff nmos_model W=5e-05 L=1e-06
M2 Drain2 Vinn SourceDiff SourceDiff nmos_model W=5e-05 L=1e-06
Mtail SourceDiff Vbias 0 0 nmos_model W=2e-05 L=1e-06
R1 Vdd Vout 10k
R2 Vdd Drain2 10k

.OP
.AC DEC 100 1 1G
.END

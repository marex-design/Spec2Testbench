* Canonical DUT generated from benchmark/analogcoder_pro/p15_amplifier.cir
* Embedded analyses and output directives were externalized into metadata.
* AnalogCoder-Pro p15: A single-stage amplifier (common-source with PMOS diode-connected load (gate and drain are shorted))
* Source: analogcoder\AnalogCoderPro-master\sample_design\p15\p15.py
* AnalogCoder-Pro type: Amplifier
* Inputs: Vin
* Outputs: Vout
.MODEL nmos_model NMOS (LEVEL=1 KP=0.0001 VTO=0.5)
.MODEL pmos_model PMOS (LEVEL=1 KP=5e-05 VTO=-0.5)
Vdd Vdd 0 5
* original signal source: Vin Vin 0 DC 1 AC 1n
Vin Vin 0 0
M1 Vout Vin 0 0 nmos_model W=5e-05 L=1e-06
M2 Vout Vout Vdd Vdd pmos_model W=5e-05 L=1e-06
* original analysis: .OP
* original analysis: .AC DEC 100 1 1G
.END

* AnalogCoder-Pro p10: a passive low-pass filter
* Source: analogcoder\AnalogCoderPro-master\sample_design\p10\p10.py
* AnalogCoder-Pro type: LowPass
* Inputs: Vin
* Outputs: Vout

Vin Vin 0 1
R1 Vin Vout 10k
C1 Vout 0 10n

.AC DEC 100 1 1G
.END

* SKY130 industrial benchmark: UP/DN charge pump
.include ../models/sky130_tt.spice

VDD vdd 0 1.8
VUP up 0 PULSE(0 1.8 5n 100p 100p 8n 20n)
VDN dn 0 PULSE(0 1.8 15n 100p 100p 8n 20n)
VBIASN vbiasn 0 0.75
VBIASP vbiasp 0 1.05

CLOAD out 0 3p
RLOAD out 0 200k

M1 out up nsrc 0 sky130_fd_pr__nfet_01v8 L=0.15u W=4.0u
M2 nsrc vbiasn 0 0 sky130_fd_pr__nfet_01v8 L=1.0u W=6.0u
M3 out dn psrc vdd sky130_fd_pr__pfet_01v8 L=0.15u W=8.0u
M4 psrc vbiasp vdd vdd sky130_fd_pr__pfet_01v8 L=1.0u W=10.0u

.end

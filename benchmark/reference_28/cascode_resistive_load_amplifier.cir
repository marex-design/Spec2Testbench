* Cascode amplifier with resistive load
Vdd vdd 0 DC 5
Vin in 0 DC 1.5 AC 1
Vbias cas 0 DC 2.5
Rd vdd out 10k
M1 n1 in 0 0 NMOS
M2 out cas n1 0 NMOS
.model NMOS NMOS LEVEL=1 VTO=1 KP=1m
.op
.ac dec 100 10 10Meg
.end
